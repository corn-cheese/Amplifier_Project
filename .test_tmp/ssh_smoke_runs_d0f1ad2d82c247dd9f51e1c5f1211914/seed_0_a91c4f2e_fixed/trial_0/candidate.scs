simulator lang=spectre
subckt bjt2stage_buf_bp VIN VREF VDD GND VOUT
CIN (VIN B1) capacitor c=2.2e-07
RB1 (B1 VREF) resistor r=68000.0
XQ1 (N1 B1 E1 GND) npn_05v5_W1p00L1p00 mult=2
RC1 (VDD N1) resistor r=10000.0
RE1 (E1 GND) resistor r=8200.0
CE1 (E1 GND) capacitor c=2.2e-06
C12 (N1 B2) capacitor c=2.2e-07
RB2 (B2 VREF) resistor r=68000.0
XQ2 (N2 B2 E2 GND) npn_05v5_W1p00L1p00 mult=2
RC2 (VDD N2) resistor r=8200.0
RE2 (E2 GND) resistor r=8200.0
CE2 (E2 GND) capacitor c=1e-06
CDOM (N2 B2) capacitor c=1e-11
XQBUF (VDD N2 VOUT GND) npn_05v5_W1p00L1p00 mult=4
ROUT (VOUT GND) resistor r=12000.0
COUT (VOUT GND) capacitor c=1e-10
ends bjt2stage_buf_bp
