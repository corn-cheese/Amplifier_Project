simulator lang=spectre
subckt bjt_amp VIN VREF VDD GND VOUT
XQ1 (VOUT VIN GND GND) npn_05v5_W1p00L1p00 mult=6
R1 (VDD VOUT) resistor r=233058.49056454047
C1 (VOUT GND) capacitor c=2.1756728642074955e-11
ends bjt_amp
