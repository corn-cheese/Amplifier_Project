simulator lang=spectre
subckt bjt_diff_mirror_buf_bp VIN VREF VDD GND VOUT
CIN VIN BIN sky130_fd_pr__cap_vpp_11p5x11p7_m1m4_noshield c=2.2e-07
RBIN BIN VREF sky130_fd_pr__res_high_po_5p73 r=68000.0 l=5.73e-6 w=3.5e-7
RREF BREF VREF sky130_fd_pr__res_high_po_5p73 r=68000.0 l=5.73e-6 w=3.5e-7
QINP NLEFT BIN TAIL GND sky130_fd_pr__npn_05v5 m=2
QINN NRIGHT BREF TAIL GND sky130_fd_pr__npn_05v5 m=2
RTAIL TAIL GND sky130_fd_pr__res_high_po_5p73 r=6800.0 l=5.73e-6 w=3.5e-7
QPL NLEFT NLEFT VDD VDD sky130_fd_pr__pnp_05v5 m=2
QPR NRIGHT NLEFT VDD VDD sky130_fd_pr__pnp_05v5 m=2
RDC NRIGHT VREF sky130_fd_pr__res_high_po_5p73 r=1000000.0 l=5.73e-6 w=3.5e-7
CDOM NRIGHT BIN sky130_fd_pr__cap_vpp_11p5x11p7_m1m4_noshield c=1.5e-11
QBUF VDD NRIGHT VOUT GND sky130_fd_pr__npn_05v5 m=4
ROUT VOUT GND sky130_fd_pr__res_high_po_5p73 r=12000.0 l=5.73e-6 w=3.5e-7
COUT VOUT GND sky130_fd_pr__cap_vpp_11p5x11p7_m1m4_noshield c=8e-11
ends bjt_diff_mirror_buf_bp
